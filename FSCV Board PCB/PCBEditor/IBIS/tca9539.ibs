| TEXAS INSTRUMENTS INCORPORATED
| Standard Linear and Logic Group
| IBIS Model of TCA9539
| REMOTE 16-BIT I2C AND SMBus LOW-POWER I/O EXPANDER WITH INTERRUPT
| OUTPUT, RESET, AND CONFIGURATION REGISTERS
| This file contains package information for the following:
|  SSOP 24-pin (DB) package as [Component] PCA9539_DB
|  SSOP 24-pin (DBQ) package as [Component] PCA9539_DBQ
|  TVSOP 24-pin (DGV) package as [Component] PCA9539_DGV
|  SOIC 24-pin (DW) package as [Component] PCA9539_DW
|  TSSOP 24-pin (PW) package as [Component] PCA9539_PW
|  QFN 24-pin (RGY) package as [Component] PCA9539_RGY
| This device can be powered at the following Vccs:
|  5 volt Vcc
|  3.3 volt Vcc
|  2.5 volt Vcc
| This file provides unique models under the [Model Selector] for each Vcc.
| For operation at a specific Vcc, select the appropriate model after each
| [Model Selector] keyword.
[IBIS Ver]   4.1
[Comment char]  |_char
[File Name]   tca9539.ibs
[File Rev]   1.0 | x_die
[Date]   May 3, 2007
[Source]   Data created from TI-SPICE simulations at TI-SLL.
[Notes]   The following is an IBIS list for the PCA9539.
   Please contact sllibis@ti.com with questions and
   comments concerning SLL IBIS models.
[Disclaimer] Property of Texas Instruments Incorporated.  Unauthorized
                reproduction and/or distribution is strictly prohibited.
                This product is protected under copyright law.
                Created  2007, (C) Copyright  2007, Texas Instruments
                Incorporated, All Rights Reserved
                UNLESS THERE IS A SIGNED, WRITTEN AGREEMENT TO THE
                CONTRARY, TEXAS INSTRUMENTS (TI) IS PROVIDING THE IBIS
                MODELS  AND WITHOUT ANY WARRANTY, EXPRESSED OR
                IMPLIED.  TI assumes no liability for:
                 1) the accuracy of the IBIS models provided to your
                    company;
                 2) the proper functioning of these IBIS Models in your
                    design or for any resulting applications; or
                 3) infringement of patents, copyrights or intellectual
                    property rights resulting from your use of these IBIS
                    models.
                TI provides IBIS Models as a service to our customers.
                You and your company shall not distribute, sell or give
                these models to anyone else without prior written
                permission from TI.
                TI reserves the right to make changes to our products or
                to discontinue any semiconductor product or service
                without notice, and advises our customers to obtain the
                latest version of relevant information to verify, before
                placing orders, that the information being relied on is
                current.
                Please be aware that your receipt and use of the IBIS
                information provided shall serve as acceptance of these
                terms and conditions.  If you do not accept these terms,
                you should return or destroy the IBIS models and any
                other accompanying information immediately.
| Component TCA9539_DB 24-PIN SSOP
[Component]   TCA9539_DB
[Manufacturer]   Texas Instruments, Inc.
[Package]
|   typ   min   max
R_pkg   4.500e-02   4.000e-02   4.900e-02
L_pkg   3.668e-09   3.226e-09   4.415e-09
C_pkg   4.160e-13   3.490e-13   5.070e-13
[Pin]   signal_name   model_name   R_pin   L_pin   C_pin
1   NINT   PCA9539_INT   4.200e-02   4.299e-09   5.030e-13
2   A1   PCA9539_A   4.000e-02   3.960e-09   4.990e-13
3   NRESET   NC   4.200e-02   3.775e-09   4.170e-13
4   P00   PCA9539_P   4.700e-02   3.487e-09   3.690e-13
5   P01   PCA9539_P   4.600e-02   3.347e-09   3.520e-13
6   P02   PCA9539_P   4.900e-02   3.352e-09   3.710e-13
7   P03   PCA9539_P   4.600e-02   3.226e-09   3.630e-13
8   P04   PCA9539_P   4.700e-02   3.289e-09   3.490e-13
9   P05   PCA9539_P   4.700e-02   3.347e-09   3.610e-13
10   P06   PCA9539_P   4.100e-02   3.576e-09   4.090e-13
11   P07   PCA9539_P   4.100e-02   3.995e-09   5.030e-13
12   GND   GND   4.500e-02   4.415e-09   5.070e-13
13   P10   PCA9539_P   4.300e-02   4.337e-09   5.060e-13
14   P11   PCA9539_P   4.200e-02   4.003e-09   5.040e-13
15   P12   PCA9539_P   4.100e-02   3.686e-09   4.100e-13
16   P13   PCA9539_P   4.800e-02   3.355e-09   3.490e-13
17   P14   PCA9539_P   4.700e-02   3.301e-09   3.530e-13
18   P15   PCA9539_P   4.800e-02   3.268e-09   3.660e-13
19   P16   PCA9539_P   4.800e-02   3.269e-09   3.660e-13
20   P17   PCA9539_P   4.700e-02   3.314e-09   3.490e-13
21   A0   PCA9539_A   4.800e-02   3.399e-09   3.550e-13
22   SCL   PCA9539_SCL   4.100e-02   3.688e-09   4.120e-13
23   SDA   PCA9539_SDA   4.200e-02   4.003e-09   5.040e-13
24   VCC   POWER   4.300e-02   4.347e-09   5.050e-13
| Component TCA9539_DBQ 24-PIN SSOP
[Component]   TCA9539_DBQ
[Manufacturer]   Texas Instruments, Inc.
[Package]
|   typ   min   max
R_pkg   4.400e-02   3.100e-02   6.600e-02
L_pkg   3.074e-09   2.348e-09   4.044e-09
C_pkg   3.220e-13   2.340e-13   4.460e-13
[Pin]   signal_name   model_name   R_pin   L_pin   C_pin
1   NINT   PCA9539_INT   6.500e-02   4.044e-09   4.290e-13
2   A1   PCA9539_A   6.600e-02   3.824e-09   4.460e-13
3   NRESET   NC   3.100e-02   3.011e-09   3.210e-13
4   P00   PCA9539_P   3.200e-02   2.699e-09   2.590e-13
5   P01   PCA9539_P   3.500e-02   2.519e-09   2.450e-13
6   P02   PCA9539_P   3.500e-02   2.348e-09   2.340e-13
7   P03   PCA9539_P   3.500e-02   2.348e-09   2.340e-13
8   P04   PCA9539_P   3.500e-02   2.518e-09   2.450e-13
9   P05   PCA9539_P   3.200e-02   2.699e-09   2.590e-13
10   P06   PCA9539_P   3.100e-02   3.011e-09   3.210e-13
11   P07   PCA9539_P   6.600e-02   3.824e-09   4.460e-13
12   GND   GND   6.500e-02   4.044e-09   4.290e-13
13   P10   PCA9539_P   6.500e-02   4.044e-09   4.290e-13
14   P11   PCA9539_P   6.600e-02   3.824e-09   4.460e-13
15   P12   PCA9539_P   3.100e-02   3.011e-09   3.210e-13
16   P13   PCA9539_P   3.200e-02   2.699e-09   2.590e-13
17   P14   PCA9539_P   3.500e-02   2.518e-09   2.450e-13
18   P15   PCA9539_P   3.500e-02   2.348e-09   2.340e-13
19   P16   PCA9539_P   3.500e-02   2.348e-09   2.340e-13
20   P17   PCA9539_P   3.500e-02   2.518e-09   2.450e-13
21   A0   PCA9539_A   3.200e-02   2.699e-09   2.590e-13
22   SCL   PCA9539_SCL   3.100e-02   3.011e-09   3.210e-13
23   SDA   PCA9539_SDA   6.600e-02   3.824e-09   4.460e-13
24   VCC   POWER   6.500e-02   4.044e-09   4.290e-13
| Component TCA9539_DGV 24-PIN TVSOP
[Component]   TCA9539_DGV
[Manufacturer]   Texas Instruments, Inc.
[Package]
|   typ   min   max
R_pkg   4.300e-02   3.900e-02   4.700e-02
L_pkg   2.601e-09   2.312e-09   3.626e-09
C_pkg   3.580e-13   2.770e-13   5.950e-13
[Pin]   signal_name   model_name   R_pin   L_pin   C_pin
1   NINT   PCA9539_INT   4.300e-02   3.625e-09   5.950e-13
2   A1   PCA9539_A   4.000e-02   2.656e-09   4.020e-13
3   NRESET   NC   3.900e-02   2.338e-09   3.080e-13
4   P00   PCA9539_P   4.600e-02   2.354e-09   2.770e-13
5   P01   PCA9539_P   4.500e-02   2.312e-09   2.850e-13
6   P02   PCA9539_P   4.700e-02   2.318e-09   2.820e-13
7   P03   PCA9539_P   4.700e-02   2.318e-09   2.820e-13
8   P04   PCA9539_P   4.500e-02   2.312e-09   2.850e-13
9   P05   PCA9539_P   4.600e-02   2.353e-09   2.780e-13
10   P06   PCA9539_P   3.900e-02   2.338e-09   3.080e-13
11   P07   PCA9539_P   4.100e-02   2.660e-09   4.020e-13
12   GND   GND   4.300e-02   3.625e-09   5.950e-13
13   P10   PCA9539_P   4.400e-02   3.626e-09   5.940e-13
14   P11   PCA9539_P   4.000e-02   2.658e-09   4.020e-13
15   P12   PCA9539_P   3.900e-02   2.343e-09   3.110e-13
16   P13   PCA9539_P   4.600e-02   2.353e-09   2.780e-13
17   P14   PCA9539_P   4.500e-02   2.312e-09   2.850e-13
18   P15   PCA9539_P   4.700e-02   2.319e-09   2.820e-13
19   P16   PCA9539_P   4.700e-02   2.319e-09   2.820e-13
20   P17   PCA9539_P   4.500e-02   2.312e-09   2.850e-13
21   A0   PCA9539_A   4.600e-02   2.353e-09   2.780e-13
22   SCL   PCA9539_SCL   3.900e-02   2.337e-09   3.080e-13
23   SDA   PCA9539_SDA   4.000e-02   2.658e-09   4.020e-13
24   VCC   POWER   4.400e-02   3.626e-09   5.950e-13
| Component TCA9539_DW 24-PIN SOIC
[Component]   TCA9539_DW
[Manufacturer]   Texas Instruments, Inc.
[Package]
|   typ   min   max
R_pkg   3.700e-02   3.000e-02   4.700e-02
L_pkg   5.146e-09   3.993e-09   6.885e-09
C_pkg   7.580e-13   5.120e-13   1.067e-12
[Pin]   signal_name   model_name   R_pin   L_pin   C_pin
1   NINT   PCA9539_INT   3.900e-02   6.885e-09   1.067e-12
2   A1   PCA9539_A   4.200e-02   5.950e-09   9.580e-13
3   NRESET   NC   4.700e-02   5.317e-09   7.910e-13
4   P00   PCA9539_P   3.100e-02   4.651e-09   6.110e-13
5   P01   PCA9539_P   3.000e-02   3.993e-09   5.120e-13
6   P02   PCA9539_P   3.000e-02   4.083e-09   6.110e-13
7   P03   PCA9539_P   3.000e-02   4.083e-09   6.110e-13
8   P04   PCA9539_P   3.000e-02   3.993e-09   5.120e-13
9   P05   PCA9539_P   3.100e-02   4.652e-09   6.110e-13
10   P06   PCA9539_P   4.700e-02   5.317e-09   7.910e-13
11   P07   PCA9539_P   4.200e-02   5.950e-09   9.590e-13
12   GND   GND   3.900e-02   6.885e-09   1.067e-12
13   P10   PCA9539_P   3.900e-02   6.885e-09   1.067e-12
14   P11   PCA9539_P   4.200e-02   5.950e-09   9.590e-13
15   P12   PCA9539_P   4.700e-02   5.317e-09   7.910e-13
16   P13   PCA9539_P   3.100e-02   4.652e-09   6.110e-13
17   P14   PCA9539_P   3.000e-02   3.993e-09   5.120e-13
18   P15   PCA9539_P   3.000e-02   4.083e-09   6.100e-13
19   P16   PCA9539_P   3.000e-02   4.083e-09   6.100e-13
20   P17   PCA9539_P   3.000e-02   3.993e-09   5.120e-13
21   A0   PCA9539_A   3.100e-02   4.651e-09   6.110e-13
22   SCL   PCA9539_SCL   4.700e-02   5.317e-09   7.910e-13
23   SDA   PCA9539_SDA   4.200e-02   5.950e-09   9.580e-13
24   VCC   POWER   3.900e-02   6.885e-09   1.067e-12
| Component PCA9539_PW 24-PIN TSSOP
[Component]   TCA9539_PW
[Manufacturer]   Texas Instruments, Inc.
[Package]
|   typ   min   max
R_pkg   3.900e-02   3.000e-02   4.600e-02
L_pkg   2.685e-09   2.367e-09   3.177e-09
C_pkg   3.200e-13   2.520e-13   4.340e-13
[Pin]   signal_name   model_name   R_pin   L_pin   C_pin
1   NINT   PCA9539_INT   3.700e-02   3.153e-09   4.340e-13
2   A1   PCA9539_A   3.400e-02   2.629e-09   3.410e-13
3   NRESET   NC   3.200e-02   2.860e-09   3.470e-13
4   P00   PCA9539_P   4.200e-02   2.741e-09   2.900e-13
5   P01   PCA9539_P   4.600e-02   2.600e-09   2.620e-13
6   P02   PCA9539_P   4.300e-02   2.414e-09   2.660e-13
7   P03   PCA9539_P   4.200e-02   2.367e-09   2.620e-13
8   P04   PCA9539_P   4.400e-02   2.461e-09   2.520e-13
9   P05   PCA9539_P   4.200e-02   2.543e-09   2.740e-13
10   P06   PCA9539_P   3.000e-02   2.616e-09   3.320e-13
11   P07   PCA9539_P   3.700e-02   2.670e-09   3.460e-13
12   GND   GND   3.900e-02   3.177e-09   4.330e-13
13   P10   PCA9539_P   3.700e-02   3.111e-09   4.310e-13
14   P11   PCA9539_P   3.700e-02   2.656e-09   3.450e-13
15   P12   PCA9539_P   3.100e-02   2.739e-09   3.400e-13
16   P13   PCA9539_P   4.200e-02   2.649e-09   2.820e-13
17   P14   PCA9539_P   4.600e-02   2.532e-09   2.570e-13
18   P15   PCA9539_P   4.400e-02   2.425e-09   2.660e-13
19   P16   PCA9539_P   4.400e-02   2.425e-09   2.660e-13
20   P17   PCA9539_P   4.600e-02   2.532e-09   2.570e-13
21   A0   PCA9539_A   4.200e-02   2.648e-09   2.820e-13
22   SCL   PCA9539_SCL   3.100e-02   2.738e-09   3.390e-13
23   SDA   PCA9539_SDA   3.600e-02   2.653e-09   3.440e-13
24   VCC   POWER   3.700e-02   3.110e-09   4.310e-13
| Component TCA9539_RGY 24-PIN QFN
[Component]   TCA9539_RGY
[Manufacturer]   Texas Instruments, Inc.
[Package]
|   typ   min   max
R_pkg   3.700e-02   2.500e-02   5.300e-02
L_pkg   8.060e-10   5.310e-10   1.139e-09
C_pkg   1.880e-13   5.700e-14   3.100e-13
[Pin]   signal_name   model_name   R_pin   L_pin   C_pin
1   NINT   PCA9539_INT   4.700e-02   1.028e-09   3.100e-13
2   A1   PCA9539_A   5.300e-02   1.139e-09   2.800e-13
3   NRESET   NC   3.400e-02   7.350e-10   2.480e-13
4   P00   PCA9539_P   3.300e-02   7.260e-10   2.460e-13
5   P01   PCA9539_P   3.200e-02   6.830e-10   2.620e-13
6   P02   PCA9539_P   3.000e-02   6.550e-10   2.410e-13
7   P03   PCA9539_P   3.000e-02   6.580e-10   2.400e-13
8   P04   PCA9539_P   3.100e-02   6.770e-10   2.330e-13
9   P05   PCA9539_P   3.500e-02   7.590e-10   2.490e-13
10   P06   PCA9539_P   3.700e-02   7.990e-10   2.540e-13
11   P07   PCA9539_P   4.500e-02   9.840e-10   2.710e-13
12   GND   GND   4.500e-02   9.870e-10   2.580e-13
13   P10   PCA9539_P   4.100e-02   8.860e-10   2.340e-13
14   P11   PCA9539_P   4.700e-02   1.014e-09   2.510e-13
15   P12   PCA9539_P   3.600e-02   7.740e-10   2.390e-13
16   P13   PCA9539_P   3.600e-02   7.870e-10   2.540e-13
17   P14   PCA9539_P   3.200e-02   7.070e-10   2.350e-13
18   P15   PCA9539_P   2.900e-02   6.430e-10   2.300e-13
19   P16   PCA9539_P   3.000e-02   6.450e-10   2.300e-13
20   P17   PCA9539_P   3.300e-02   7.100e-10   2.360e-13
21   A0   PCA9539_A   3.800e-02   8.150e-10   2.570e-13
22   SCL   PCA9539_SCL   3.600e-02   7.750e-10   2.390e-13
23   SDA   PCA9539_SDA   4.700e-02   1.015e-09   2.510e-13
24   VCC   POWER   4.100e-02   8.850e-10   2.360e-13
| Model PCA9539_A
[Model Selector]   PCA9539_A
PCA9539_A_50   5 volt Vcc
PCA9539_A_33   3.3 volt Vcc
PCA9539_A_25   2.5 volt Vcc
| Model PCA9539_SCL
[Model Selector]   PCA9539_SCL
PCA9539_SCL_50   5 volt Vcc
PCA9539_SCL_33   3.3 volt Vcc
PCA9539_SCL_25   2.5 volt Vcc
| Model PCA9539_P
[Model Selector]   PCA9539_P
PCA9539_P_50   5 volt Vcc
PCA9539_P_33   3.3 volt Vcc
PCA9539_P_25   2.5 volt Vcc
| Model PCA9539_SDA
[Model Selector]   PCA9539_SDA
PCA9539_SDA_50   5 volt Vcc
PCA9539_SDA_33   3.3 volt Vcc
PCA9539_SDA_25   2.5 volt Vcc
| Model PCA9539_INT
[Model Selector]   PCA9539_INT
PCA9539_INT_50   5 volt Vcc
PCA9539_INT_33   3.3 volt Vcc
PCA9539_INT_25   2.5 volt Vcc
| Models and submodels in the file (15): PCA9539_A_50 (Input), PCA9539_A_33 (Input), PCA9539_A_25 (Input), PCA9539_SCL_50 (Input), PCA9539_SCL_33 (Input), PCA9539_SCL_25 (Input), PCA9539_P_50 (I/O), PCA9539_P_33 (I/O), PCA9539_P_25 (I/O), PCA9539_SDA_50 (I/O_open_drain), PCA9539_SDA_33 (I/O_open_drain), PCA9539_SDA_25 (I/O_open_drain), PCA9539_INT_50 (Open_drain), PCA9539_INT_33 (Open_drain), PCA9539_INT_25 (Open_drain)
